# Ansys Electronics Desktop project, version 2024.2
materials:
  vacuum: permittivity=1
  pec: conductivity=1e+30

design HFSSDesign1 (HFSS, HFSS Modal Network, model units mm)
geometry:
  waveguide_WR90 [vacuum] = box(corner=(-5.08mm, -11.43mm, 0mm), size=(10.16mm, 22.86mm, 30mm))
  Rectangle1 = rectangle(corner=(-5.08mm, 11.43mm, 30mm), x_size=10.16mm, y_size=-22.86mm)
  Rectangle2 = rectangle(corner=(-55mm, -74mm, 220mm), x_size=110mm, y_size=148mm)
  Rectangle2.connect(Rectangle1)
  Box1 [vacuum] = box(corner=(-185mm, -215mm, -120mm), size=(150mm, 180mm, 235mm))
  waveguide_WR90_Section1 [pec] = waveguide_WR90.section(plane=XY)
  Box1.move(0mm, 50mm, 150mm)
  Box1.move(79.96mm, 157.285mm, 0mm)
  Box1.move(50.04mm, 2.715mm, -5mm)
  Box1.move(-20mm, 0mm, 0mm)
  Box1.move(0mm, -8.6201798mm, -31.311585mm)
  Box1.move(0mm, -76.37982mm, 6.3115846mm)
  waveguide_WR90.unite(Rectangle2)
boundaries and excitations:
  Rad1: Radiation Faces=Box1.face(all 6)
  PerfE1: Perfect E Faces=waveguide_WR90.face(at (0, 42.715, 125), at (-30.04, 0, 125), at (30.04, 0, 125), at (0, -42.715, 125), -y, -x, +y, +x)
  1: Wave Port Objects=waveguide_WR90_Section1 WavePortType=Modal NumModes=1 Modes{Mode1{IntLine{(0, -11.43, 0) -> (0, 11.43, 0)} CharImp=Zpi}}
setups:
  Setup1: HfssDriven Frequency=10GHz MaxDeltaS=0.02 MaximumPasses=15 MinimumPasses=1 MinimumConvergedPasses=1 PercentRefinement=30 BasisOrder=1 PortAccuracy=2 DrivenSolverType="Direct Solver"
    sweep Sweep1: 8GHz to 12GHz, 201 points; Type=Interpolating InterpTolerance=0.5 InterpMaxSolns=250 InterpUsePortImped=false PassivityErrorTolerance=0.0001
source amplitudes:
  1:1: 1W 0deg
radiation setups:
  Infinite Sphere1: Infinite Sphere Theta=0deg..180deg step 2deg Phi=-180deg..180deg step 2deg
field plots:
  Vector_E1: E Field over waveguide_WR90.face(at (0, 0, 220), at (0, -42.715, 125), at (30.04, 0, 125), at (0, 42.715, 125), at (-30.04, 0, 125)) on Setup1 : LastAdaptive at Freq=10GHz Phase=0deg
  Vector_H1: H Field over waveguide_WR90.face(at (0, 0, 220), at (0, -42.715, 125), at (30.04, 0, 125), at (0, 42.715, 125), at (-30.04, 0, 125)) on Setup1 : LastAdaptive at Freq=10GHz Phase=0deg
reports:
  S Parameter Plot 1: dB(S(1,1)) vs Freq on Setup1 : Sweep1
  VSWR Plot 1: VSWR(1) vs Freq on Setup1 : Sweep1
  Gain Plot: GainTotal vs Phi, Theta on Setup1 : LastAdaptive, Infinite Sphere1 [Freq=10GHz]
